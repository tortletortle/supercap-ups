* V1.4 diagnostic-only: direct TPS61088 internal timing-node probe (Gear 25 ns sensitivity)
* No circuit elements, component values, model contents or measurements changed.
* Only the saved vectors and .tran maximum step (25 ns) differ from the original baseline.
* Hierarchical .save vectors are observations only; preserve original baseline separately.
* TI TPS61088 macro-model. MODE=0 is forced PWM per TI datasheet.
* This deck is a test input only; no simulation result is implied.
.include ../../tps61088_v1_3/model/TPS61088_LT.LIB
V1 source 0 7
RS source vin 0.002
VEN en 0 PWL(0 0 100u 0 101u 3)
CIN vin 0 35u
L1 vin sw 3.3u Rser=0.026
CBOOT boot sw 100n
CVCC vcc 0 4.7u
CSS ss 0 47n
RCOMP comp cm 21.5k
CCOMP cm 0 13n
CHF comp 0 100p
RFSW fsw sw 324k
RILIM ilim 0 100k
RUP vout fb 1.076meg
RDN fb 0 120k
COUT vout 0 47u Rser=0.003
VLOAD vout load 0
BLOAD load 0 I=min(max(V(load)/10,0),1)
X1 0 boot comp en fb fsw ilim 0 nc0 nc1 0 ss sw sw sw sw vcc vin vout vout vout TPS61088_TRANS
.save V(vin) V(vout) V(sw) V(fsw) V(en) V(comp) V(ss) I(V1) I(L1) I(VLOAD) I(RFSW) V(X1:U5_PVIN) V(X1:U5_N01584) V(X1:U5_IFSW) V(X1:U5_TSW) V(X1:U5_TDELAY_SW) V(X1:U5_TOFF) V(X1:U5_TEND) V(X1:GATE_L) V(X1:SSEND) V(X1:MODE_OK) V(X1:U5_SEL_TOFF) V(X1:U5_TOFF_SEL) V(X1:U5_TOFF_SEL_1) V(X1:U5_N16903113)
.options method=gear reltol=.003 trtol=7 gmin=1e-10 numdgt=7 threads=1 plotwinsize=0
.tran 0 26m 0 25n
.meas tran t90 WHEN V(vout)=10.8 RISE=1
.meas tran t98 WHEN V(vout)=11.76 RISE=1
* Late edge counts are intended to fall after soft-start; inspect V(sw) for ringing.
.meas tran sw_t6001 WHEN V(sw)=10 RISE=6001
.meas tran sw_t6101 WHEN V(sw)=10 RISE=6101
.meas tran f_sw_khz PARAM 0.1/(sw_t6101-sw_t6001)
.meas tran avg_vout AVG V(vout) FROM 24m TO 26m
.meas tran ripple PP V(vout) FROM 24m TO 26m
.meas tran peak_i MAX I(L1) FROM 24m TO 26m
.meas tran peak_start MAX I(L1) FROM 0 TO 26m
.meas tran iin_avg AVG (-I(V1)) FROM 24m TO 26m
.meas tran iout_avg AVG I(VLOAD) FROM 24m TO 26m
.meas tran pin_avg AVG (-V(vin)*I(V1)) FROM 24m TO 26m
.meas tran pout_avg AVG (V(vout)*I(VLOAD)) FROM 24m TO 26m
.meas tran eta_pct PARAM 100*pout_avg/pin_avg
.end
