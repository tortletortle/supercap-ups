* BACKUP_READY residual-voltage/current-limit counterexample.
* Behavioral SPICE only: no TPS25947/TPS2121 vendor macromodels.
* The limited-current path is an abstract fault-state stimulus, not an eFuse macro.

.param VBOOST_V=12
.param RPATH=45m
.param COUT100=100u
.param COUT470=470u
.param RBLEED=10k
.param IPROOF=1
.param TPROOF=200u
.param TPROOF_START=1.1m
.param ILIMITED_100=425m
.param ILIMITED_470=575m
.param PG_RATIO=0.105
.param VPG_FALL_MAX=1.116
.param VPG_RISE_MAX=1.223
.param VPATH_DROP_MAX=100m
.param VOUT_MIN=11.8

VBOOST boost 0 {VBOOST_V}
* Precharge the output capacitors, then transition to a current-limited source.
VEFUSE_CTRL efuse_ctrl 0 PWL(0 5 99u 5 100u 0 3m 0)
VFAULT_CTRL fault_ctrl 0 PWL(0 0 99u 0 100u 5 3m 5)
.model EFUSE_SW SW(Ron={RPATH} Roff=1G Vt=2.5 Vh=0.1)
S_PRECHARGE100 boost out100 efuse_ctrl 0 EFUSE_SW
S_PRECHARGE470 boost out470 efuse_ctrl 0 EFUSE_SW

* Fault-state path current is bracketed at 0.425 A / 0.575 A.
* These are the MIN/MAX limits for one TI R_ILM=6.65 kOhm setting;
* they are not the project's selected R_ILM or a full device model.
* A smooth tanh transition avoids a hard comparator discontinuity at VOUT=VIN.
BLIMITED_PATH100 boost out100 I = V(fault_ctrl)>2.5 ? {ILIMITED_100}*tanh(100*(V(boost)-V(out100))) : 0
BLIMITED_PATH470 boost out470 I = V(fault_ctrl)>2.5 ? {ILIMITED_470}*tanh(100*(V(boost)-V(out470))) : 0

COUT_100 out100 0 {COUT100}
COUT_470 out470 0 {COUT470}
RBLEED_100 out100 0 {RBLEED}
RBLEED_470 out470 0 {RBLEED}

* A healthy path with 45 mOhm series resistance is the positive control.
RPATH_LIVE boost out_live {RPATH}
COUT_LIVE out_live 0 100u
RBLEED_LIVE out_live 0 {RBLEED}

* 1 A / 200 us proof pulse while the main source still powers the system load.
IPROOF_100 out100 0 PULSE(0 {IPROOF} {TPROOF_START} 1n 1n {TPROOF} 10m)
IPROOF_470 out470 0 PULSE(0 {IPROOF} {TPROOF_START} 1n 1n {TPROOF} 10m)
IPROOF_LIVE out_live 0 PULSE(0 {IPROOF} {TPROOF_START} 1n 1n {TPROOF} 10m)

* PGTH divider. PG is already asserted before the fault. It deasserts only
* when PGTH falls below the falling threshold; output-short PG can stay high
* when PGTH is above the rising threshold.
BPG_100 pg100 0 V = V(out100)*{PG_RATIO} > {VPG_FALL_MAX} ? 5 : 0
BPG_470 pg470 0 V = V(out470)*{PG_RATIO} > {VPG_FALL_MAX} ? 5 : 0
BPG_LIVE pg_live 0 V = V(out_live)*{PG_RATIO} > {VPG_RISE_MAX} ? 5 : 0

* TPS259470A output-short status behavior: AUXOFF and FLT remain high.
VAUXOFF_470A auxoff470a 0 5
VFLT_470A flt470a 0 5

* Live proof comparator: path drop <=100 mV AND OUT >=11.8 V.
BPROOF_100 proof100 0 V = ((V(boost)-V(out100) < {VPATH_DROP_MAX}) && (V(out100) > {VOUT_MIN})) ? 5 : 0
BPROOF_470 proof470 0 V = ((V(boost)-V(out470) < {VPATH_DROP_MAX}) && (V(out470) > {VOUT_MIN})) ? 5 : 0
BPROOF_LIVE proof_live 0 V = ((V(boost)-V(out_live) < {VPATH_DROP_MAX}) && (V(out_live) > {VOUT_MIN})) ? 5 : 0

* Sample the proof result once, while the 200 us pulse is still active.
* The capacitor holds the decision after the OUT voltage recovers.
VPROOF_STROBE proof_strobe 0 PULSE(0 5 1.299m 1n 1n 500n 10m)
.model PROOF_SAMPLE_SW SW(Ron=10m Roff=1G Vt=2.5 Vh=0.1)
SAMPLE_PROOF100 proof100 proof_latched100 proof_strobe 0 PROOF_SAMPLE_SW
SAMPLE_PROOF470 proof470 proof_latched470 proof_strobe 0 PROOF_SAMPLE_SW
SAMPLE_PROOF_LIVE proof_live proof_latched_live proof_strobe 0 PROOF_SAMPLE_SW
CPROOF_LATCH100 proof_latched100 0 1u
CPROOF_LATCH470 proof_latched470 0 1u
CPROOF_LATCH_LIVE proof_latched_live 0 1u
RPROOF_LATCH100 proof_latched100 0 1G
RPROOF_LATCH470 proof_latched470 0 1G
RPROOF_LATCH_LIVE proof_latched_live 0 1G

* Hold all other BACKUP_READY qualifiers valid in this focused eFuse test.
VARM_LATCHED arm_latched 0 5
VCELL_PERMIT cell_permit 0 5
VPACK_UV_OK pack_uv_ok 0 5
VBOOST_EN boost_en 0 5
VBOOST_IN_WINDOW boost_in_window 0 5
VBOOST_OUT_WINDOW boost_out_window 0 5
VPATH_PROOF_FRESH path_proof_fresh 0 5
VBACKUP_FAULT_LATCH backup_fault_latch 0 0
VSTARTUP_TIMEOUT startup_timeout 0 0

* BACKUP_READY includes every required system qualifier plus variant status
* and the latched path proof. Status pins alone cannot assert READY.
BREADY_470A ready470a 0 V = ((V(arm_latched)>2.5) && (V(cell_permit)>2.5) && (V(pack_uv_ok)>2.5) && (V(boost_en)>2.5) && (V(boost_in_window)>2.5) && (V(boost_out_window)>2.5) && (V(auxoff470a)>2.5) && (V(flt470a)>2.5) && (V(proof_latched470)>2.5) && (V(path_proof_fresh)>2.5) && (V(backup_fault_latch)<2.5) && (V(startup_timeout)<2.5)) ? 5 : 0
BREADY_474L ready474l 0 V = ((V(arm_latched)>2.5) && (V(cell_permit)>2.5) && (V(pack_uv_ok)>2.5) && (V(boost_en)>2.5) && (V(boost_in_window)>2.5) && (V(boost_out_window)>2.5) && (V(pg470)>2.5) && (V(proof_latched470)>2.5) && (V(path_proof_fresh)>2.5) && (V(backup_fault_latch)<2.5) && (V(startup_timeout)<2.5)) ? 5 : 0
BREADY_LIVE ready_live 0 V = ((V(arm_latched)>2.5) && (V(cell_permit)>2.5) && (V(pack_uv_ok)>2.5) && (V(boost_en)>2.5) && (V(boost_in_window)>2.5) && (V(boost_out_window)>2.5) && (V(pg_live)>2.5) && (V(proof_latched_live)>2.5) && (V(path_proof_fresh)>2.5) && (V(backup_fault_latch)<2.5) && (V(startup_timeout)<2.5)) ? 5 : 0

* Main source is removed at 1.5 ms. Compare voltage-only selection against
* selection gated by BACKUP_READY. MUX switches are idealized behavioral logic.
VMAIN main 0 PWL(0 12 1.499m 12 1.5m 0 3m 0)
.model MUX_SW SW(Ron=20m Roff=1G Vt=2.5 Vh=0.1)
BMAIN_SEL_V main_sel_v 0 V = V(main)>11.2 ? 5 : 0
BBACKUP_SEL_V backup_sel_v 0 V = ((V(main)<11.2) && (V(out470)>2.8)) ? 5 : 0
SMAIN_V main load_voltage_only main_sel_v 0 MUX_SW
SBACKUP_V out470 load_voltage_only backup_sel_v 0 MUX_SW
RLOAD_V load_voltage_only 0 12
CLOAD_V load_voltage_only 0 100u

BMAIN_SEL_Q main_sel_q 0 V = V(main)>11.2 ? 5 : 0
BBACKUP_SEL_Q backup_sel_q 0 V = ((V(main)<11.2) && (V(ready474l)>2.5)) ? 5 : 0
SMAIN_Q main load_qualified main_sel_q 0 MUX_SW
SBACKUP_Q out470 load_qualified backup_sel_q 0 MUX_SW
RLOAD_Q load_qualified 0 12
CLOAD_Q load_qualified 0 100u

* Positive control: a healthy, independently qualified backup path transfers.
BMAIN_SEL_L main_sel_l 0 V = V(main)>11.2 ? 5 : 0
BBACKUP_SEL_L backup_sel_l 0 V = ((V(main)<11.2) && (V(ready_live)>2.5)) ? 5 : 0
SMAIN_L main load_qualified_live main_sel_l 0 MUX_SW
SBACKUP_L out_live load_qualified_live backup_sel_l 0 MUX_SW
RLOAD_L load_qualified_live 0 12
CLOAD_L load_qualified_live 0 100u

.options method=gear reltol=1e-4 abstol=1e-9 vntol=1e-6

.control
set wr_singlescale
set wr_vecnames
tran 1u 3m 0 1u
meas tran live_during_proof find v(out_live) at=1.2m
meas tran residual100_after_proof find v(out100) at=1.2995m
meas tran residual470_after_proof find v(out470) at=1.2995m
meas tran pg100_after_proof find v(pg100) at=1.2995m
meas tran pg470_after_proof find v(pg470) at=1.2995m
meas tran proof100_latched_after find v(proof_latched100) at=2.5m
meas tran proof470_latched_after find v(proof_latched470) at=2.5m
meas tran proof_live_latched_after find v(proof_latched_live) at=2.5m
meas tran ready470a_after find v(ready470a) at=2.5m
meas tran ready474l_after find v(ready474l) at=2.5m
meas tran load_voltage_only_after find v(load_voltage_only) at=2.5m
meas tran load_qualified_after find v(load_qualified) at=2.5m
meas tran load_qualified_live_after find v(load_qualified_live) at=2.5m
write backup_ready_residual_fault.raw all
wrdata backup_ready_residual_fault.csv v(out_live) v(out100) v(out470) v(pg100) v(pg470) v(proof100) v(proof470) v(proof_live) v(proof_latched100) v(proof_latched470) v(proof_latched_live) v(ready470a) v(ready474l) v(ready_live) v(main) v(load_voltage_only) v(load_qualified) v(load_qualified_live)
quit
.endc
.end
