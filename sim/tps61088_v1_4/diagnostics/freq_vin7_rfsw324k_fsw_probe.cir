* V1.4 diagnostic-only copy of freq_vin7_rfsw324k.cir
* Electrical components, values, solver settings and frequency measurement are unchanged.
* Only additional saved signals and measurements are added to inspect the FSW timing path.
.include ../../tps61088_v1_3/model/TPS61088_LT.LIB
V1 source 0 7
RS source vin 0.002
VEN en 0 PWL(0 0 100u 0 101u 3)
CIN vin 0 35u
L1 vin sw 3.3u Rser=0.026
CBOOT boot sw 100n
CVCC vcc 0 4.7u
CSS ss 0 47n
RCOMP comp cm 21.5k
CCOMP cm 0 13n
CHF comp 0 100p
RFSW fsw sw 324k
RILIM ilim 0 100k
RUP vout fb 1.076meg
RDN fb 0 120k
COUT vout 0 47u Rser=0.003
VLOAD vout load 0
BLOAD load 0 I=min(max(V(load)/10,0),1)
X1 0 boot comp en fb fsw ilim 0 nc0 nc1 0 ss sw sw sw sw vcc vin vout vout vout TPS61088_TRANS
.save V(vin) V(vout) V(sw) V(fsw) V(en) V(comp) V(ss) I(V1) I(L1) I(VLOAD) I(RFSW)
.options method=gear reltol=.003 trtol=7 gmin=1e-10 numdgt=7 threads=1 plotwinsize=0
.tran 0 26m 0 50n
.meas tran t90 WHEN V(vout)=10.8 RISE=1
.meas tran t98 WHEN V(vout)=11.76 RISE=1
.meas tran sw_t6001 WHEN V(sw)=10 RISE=6001
.meas tran sw_t6101 WHEN V(sw)=10 RISE=6101
.meas tran f_sw_khz PARAM 0.1/(sw_t6101-sw_t6001)
.meas tran avg_vout AVG V(vout) FROM 24m TO 26m
.meas tran ripple PP V(vout) FROM 24m TO 26m
.meas tran peak_i MAX I(L1) FROM 24m TO 26m
.meas tran peak_start MAX I(L1) FROM 0 TO 26m
.meas tran avg_vsw AVG V(sw) FROM 24m TO 26m
.meas tran avg_vfsw AVG V(fsw) FROM 24m TO 26m
.meas tran min_vfsw MIN V(fsw) FROM 24m TO 26m
.meas tran max_vfsw MAX V(fsw) FROM 24m TO 26m
.meas tran avg_rfsw_current AVG I(RFSW) FROM 24m TO 26m
.meas tran pp_rfsw_current PP I(RFSW) FROM 24m TO 26m
.end
