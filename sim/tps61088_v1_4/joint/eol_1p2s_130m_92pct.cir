* V1.4 EOL 1.2-s checkpoint: 4S 6.3F, 130mOhm/cell, 60mOhm path
* Prebias from behavioral constant-power model at eta_boost=92%, path eta=99%.
* 18-ms local switching window only; NOT a continuous 1.2-s switching simulation.
* Input decoupling starts precharged to the battery open-circuit voltage before EN; this avoids an unrelated empty-input-cap inrush in this prebiased checkpoint.
.include ../../tps61088_v1_3/model/TPS61088_LT.LIB
VSENSE SRC VIN 0
RPATH N4 SRC 0.06
CIN VIN 0 35u IC=8.107558690853
CINHF VIN 0 100n IC=8.107558690853
L1 VIN LD 3.3u
RLD LD SW 0.026
CBOOT BOOT SW 100n
CVCC VCC 0 4.7u
CSS SS 0 47n IC=1.5
RCOMP COMP CM 21.5k
CCOMP CM 0 13n
CHF COMP 0 100p
RFSW FSW SW 324k
RILIM ILIM 0 174k
RUP OUT FB 1.076meg
RDN FB 0 120k
COUT OUT 0 47u Rser=0.003 IC=12
BLOAD OUT 0 I=min(max(V(OUT)/10,0),1)
VEN EN 0 PULSE(0 3 100u 1u 1u 1 2)
CSTORE1 P1 0 6.3 IC=2.026889672713
RESR1 P1 N1 0.13
CSTORE2 P2 N1 6.3 IC=2.026889672713
RESR2 P2 N2 0.13
CSTORE3 P3 N2 6.3 IC=2.026889672713
RESR3 P3 N3 0.13
CSTORE4 P4 N3 6.3 IC=2.026889672713
RESR4 P4 N4 0.13
.ic V(P1)=2.026889672713 V(N1)=2.026889672713 V(P2)=4.053779345426 V(N2)=4.053779345426 V(P3)=6.080669018139 V(N3)=6.080669018139 V(P4)=8.107558690853 V(N4)=8.107558690853
* Pin order: AGND BOOT COMP EN FB FSW ILIM MODE NC0 NC1 PGND SS ...
* MODE=0 is FPWM, matching the single-source BOM decks.
X1 0 BOOT COMP EN FB FSW ILIM 0 NC0 NC1 0 SS SW SW SW SW VCC VIN OUT OUT OUT TPS61088_TRANS
.save V(SRC) V(VIN) V(OUT) V(EN) V(COMP) V(SS) V(SW) I(VSENSE) I(L1) I(BLOAD)
.options method=gear reltol=.003 trtol=7 gmin=1e-10 numdgt=7
.tran 0 18m 0 100n uic
.meas tran vsrc_avg AVG V(SRC) from 15m to 17m
.meas tran vin_avg AVG V(VIN) from 15m to 17m
.meas tran vout_avg AVG V(OUT) from 15m to 17m
.meas tran vout_min MIN V(OUT) from 15m to 17m
.meas tran vout_max MAX V(OUT) from 15m to 17m
.meas tran il_peak MAX I(L1) from 15m to 17m
.meas tran iin_avg AVG I(VSENSE) from 15m to 17m
.meas tran pin_avg AVG (V(SRC)*I(VSENSE)) from 15m to 17m
.meas tran pout_avg AVG (V(OUT)*I(BLOAD)) from 15m to 17m
.meas tran eta_input_pct PARAM 100*pout_avg/pin_avg
.end
