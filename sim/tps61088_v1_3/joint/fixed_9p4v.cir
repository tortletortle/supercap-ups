* DC V1.3 | fixed_9p4v | fixed input behavior-load reference
.include ../model/TPS61088_LT.LIB
VINPUT SRC 0 DC 9.4
VSENSE SRC VIN 0
CIN VIN 0 35u
CINHF VIN 0 100n
L1 VIN LD 3.3u
RLD LD SW 0.020
CBOOT BOOT SW 100n
CVCC VCC 0 4.7u
CSS SS 0 47n IC=1.5
RCOMP COMP CM 21.5k
CCOMP CM 0 13n
CHF COMP 0 100p
RFSW FSW SW 324k
RILIM ILIM 0 100k
RUP OUT FB 1.07meg
RDN FB 0 120k
COUT OUT 0 47u Rser=0.003 IC=12
BLOAD OUT 0 I=min(max(V(OUT)/10,0),1)
VEN EN 0 PULSE(0 3 100u 1u 1u 1 2)
X1 0 BOOT COMP EN FB FSW ILIM VCC NC0 NC1 0 SS SW SW SW SW VCC VIN OUT OUT OUT TPS61088_TRANS
.save V(SRC) V(VIN) V(OUT) V(EN) V(COMP) V(SS) V(SW) I(VSENSE) I(L1) I(BLOAD)
.options method=gear reltol=.003 trtol=7 gmin=1e-10 numdgt=7
.tran 0 18m 0 100n uic
.meas tran vout_avg AVG V(OUT) from 15m to 17m
.meas tran vout_min MIN V(OUT) from 15m to 17m
.meas tran vout_max MAX V(OUT) from 15m to 17m
.meas tran il_peak MAX I(L1) from 15m to 17m
.meas tran iin_avg AVG I(VSENSE) from 15m to 17m
.meas tran vsrc_avg AVG V(SRC) from 15m to 17m
.meas tran pin_avg AVG (V(SRC)*I(VSENSE)) from 15m to 17m
.meas tran pout_avg AVG (V(OUT)*I(BLOAD)) from 15m to 17m
.meas tran eta_avg PARAM 100*pout_avg/pin_avg
.end
