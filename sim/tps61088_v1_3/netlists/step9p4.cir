* TPS61088 TI SLVMAU6A macro, forced PWM mode, 0.5?1 A OCP-safe load steps
.include ../model/TPS61088_LT.LIB
V1 source 0 9.4
RS source vin 0.002
VEN en 0 PWL(0 0 100u 0 101u 3)
CIN vin 0 35u
L1 vin sw 3.3u Rser=0.020
CBOOT boot sw 100n
CVCC vcc 0 4.7u
CSS ss 0 47n
RCOMP comp cm 21.5k
CCOMP cm 0 13n
CHF comp 0 100p
RFSW fsw sw 324k
RILIM ilim 0 100k
RUP vout fb 1.07meg
RDN fb 0 120k
COUT vout 0 47u Rser=0.003
VLOAD vout load 0
ILOAD load 0 PWL(0 0 300u 0 301u 0.5 13.5m 0.5 13.501m 1 16m 1 16.001m 0.5)
X1 0 boot comp en fb fsw ilim 0 nc0 nc1 0 ss sw sw sw sw vcc vin vout vout vout TPS61088_TRANS
.save V(vin) V(vout) V(sw) V(en) V(comp) V(ss) I(V1) I(L1) I(VLOAD)
.options method=gear reltol=.003 trtol=7 gmin=1e-10 threads=2 plotwinsize=0
.tran 0 17.5m 0 100n
.meas tran t_en WHEN V(en)=1.2 RISE=1
.meas tran t_10pct WHEN V(vout)=1.2 RISE=1
.meas tran t_90pct WHEN V(vout)=10.8 RISE=1
.meas tran t_98pct WHEN V(vout)=11.76 RISE=1
.meas tran stepup_pre AVG V(vout) from 13.3m to 13.49m
.meas tran stepup_min MIN V(vout) from 13.5m to 14.5m
.meas tran full_vout AVG V(vout) from 15.3m to 15.9m
.meas tran full_ripple PP V(vout) from 15.3m to 15.9m
.meas tran full_peak_i MAX I(L1) from 15.3m to 15.9m
.meas tran e_in INTEG (-V(vin)*I(V1)) from 15.3m to 15.9m
.meas tran e_out INTEG (V(vout)*I(VLOAD)) from 15.3m to 15.9m
.meas tran eta_pct param (100*e_out/e_in)
.meas tran stepdown_max MAX V(vout) from 16m to 17m
.meas tran stepdown_final AVG V(vout) from 17.3m to 17.5m
.end
