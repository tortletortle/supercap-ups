* DC V1.3 bom_9p4, TPS61088 official SLVMAU6A with two equivalent literal edits
.include ../model/TPS61088_LT.LIB
V1 source 0 9.4
RS source vin 0.002
VEN en 0 PWL(0 0 100u 0 101u 3)
CIN vin 0 35u
L1 vin sw 3.3u Rser=.026
CBOOT boot sw 100n
CVCC vcc 0 4.7u
CSS ss 0 47n
RCOMP comp cm 21.5k
CCOMP cm 0 13n
CHF comp 0 100p
RFSW fsw sw 324k
RILIM ilim 0 100k
RUP vout fb 1.076meg
RDN fb 0 120k
COUT1 vout c1 22u
RCOUT1 c1 0 .003
COUT2 vout c2 22u
RCOUT2 c2 0 .003
COUT3 vout c3 22u
RCOUT3 c3 0 .003
COUT4 vout c4 22u
RCOUT4 c4 0 .003
VLOAD vout load 0
BLOAD load 0 I=min(max(V(load)/10,0),1)
X1 0 boot comp en fb fsw ilim 0 nc0 nc1 0 ss sw sw sw sw vcc vin vout vout vout TPS61088_TRANS
.save V(vin) V(vout) V(sw) V(en) V(comp) V(ss) I(V1) I(L1) I(VLOAD)
.options method=gear reltol=.003 trtol=7 gmin=1e-10 numdgt=7 threads=1 plotwinsize=0
.tran 0 18m 0 100n
.meas tran vin_avg AVG V(vin) from 16m to 18m
.meas tran avg_vout AVG V(vout) from 16m to 18m
.meas tran vmin MIN V(vout) from 16m to 18m
.meas tran vmax MAX V(vout) from 16m to 18m
.meas tran ripple PP V(vout) from 16m to 18m
.meas tran peak_i MAX I(L1) from 16m to 18m
.meas tran peak_start MAX I(L1) from 0 to 16m
.meas tran iin_avg AVG (-I(V1)) from 16m to 18m
.meas tran iout_avg AVG I(VLOAD) from 16m to 18m
.meas tran pin AVG (-V(vin)*I(V1)) from 16m to 18m
.meas tran pout AVG (V(vout)*I(VLOAD)) from 16m to 18m
.meas tran eff PARAM 100*pout/pin
.meas tran t_en WHEN V(en)=1.2 RISE=1
.meas tran t98 WHEN V(vout)=11.76 RISE=1
.meas tran sw_t1 WHEN V(sw)=10 RISE=1
.meas tran sw_t101 WHEN V(sw)=10 RISE=101
.meas tran sw_t5001 WHEN V(sw)=10 RISE=5001
.meas tran sw_t6001 WHEN V(sw)=10 RISE=6001
.end
