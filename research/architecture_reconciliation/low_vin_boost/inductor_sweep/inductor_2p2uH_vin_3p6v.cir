* Inductor candidate stress sweep: CKST0603-2.2uH/M, VIN=3.6 V, 12 V / 1 A
* Worst-case tolerance corner: L minimum after -20%, DCR maximum.
* Isat/Irms metadata are manufacturer typical references, not guaranteed limits.
* MODE=GND_FPWM, RILIM=100k; TI datasheet minimum FPWM limit is 9.0 A.
.include ../../../../sim/tps61088_v1_3/model/TPS61088_LT.LIB
V1 source 0 3.6
RS source vin 0.002
VEN en 0 PWL(0 0 100u 0 101u 3)
CIN vin 0 35u
L1 vin sw 1.76u Rser=0.0175
CBOOT boot sw 100n
CVCC vcc 0 4.7u
CSS ss 0 47n
RCOMP comp cm 21.5k
CCOMP cm 0 13n
CHF comp 0 100p
RFSW fsw sw 324k
RILIM ilim 0 100k
RUP vout fb 1.076meg
RDN fb 0 120k
COUT vout 0 47u Rser=.003
VLOAD vout load 0
BLOAD load 0 I=min(max(V(load)/10,0),1)
X1 0 boot comp en fb fsw ilim 0 nc0 nc1 0 ss sw sw sw sw vcc vin vout vout vout TPS61088_TRANS
.save V(vin) V(vout) V(sw) V(en) V(comp) V(ss) I(V1) I(L1) I(VLOAD)
.options method=gear reltol=.003 trtol=7 gmin=1e-10 numdgt=7 threads=1 plotwinsize=0
.tran 0 40m 0 50n
.meas tran vin_avg AVG V(vin) from 35m to 37m
.meas tran avg_vout AVG V(vout) from 35m to 37m
.meas tran vmin MIN V(vout) from 35m to 37m
.meas tran vmax MAX V(vout) from 35m to 37m
.meas tran ripple PP V(vout) from 35m to 37m
.meas tran peak_i MAX I(L1) from 35m to 37m
.meas tran peak_start MAX I(L1) from 0 to 35m
.meas tran il_avg AVG I(L1) from 35m to 37m
.meas tran il_rms RMS I(L1) from 35m to 37m
.meas tran iin_avg AVG (-I(V1)) from 35m to 37m
.meas tran iout_avg AVG I(VLOAD) from 35m to 37m
.meas tran pin AVG (-V(vin)*I(V1)) from 35m to 37m
.meas tran pout AVG (V(vout)*I(VLOAD)) from 35m to 37m
.meas tran eff PARAM 100*pout/pin
.meas tran t_en WHEN V(en)=1.2 RISE=1
.meas tran t98 WHEN V(vout)=11.76 RISE=1
.meas tran t98_delay PARAM t98-t_en
.meas tran sw_t6001 WHEN V(sw)=10 RISE=6001
.meas tran sw_t6101 WHEN V(sw)=10 RISE=6101
.meas tran f_sw_khz PARAM 100/(sw_t6101-sw_t6001)/1000
.end
